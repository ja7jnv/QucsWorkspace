* Qucs 25.1.0  /home/shigeaki/QucsWorkspace/practice_prj/stepAtt_Sparam.sch
.INCLUDE "/usr/share/qucs-s/xspice_cmlib/include/ngspice_mathfunc.inc"
.SUBCKT att_2dB _net1 _net0
R3 0 _net0  442 tc1=0.0 tc2=0.0
R1 0 _net1  442 tc1=0.0 tc2=0.0
R2 _net1 _net0  11.5 tc1=0.0 tc2=0.0
.ENDS
.SUBCKT att_1dB _net1 _net0
R2 _net1 _net0  5.9 tc1=0.0 tc2=0.0
R1 0 _net1  866 tc1=0.0 tc2=0.0
R3 0 _net0  866 tc1=0.0 tc2=0.0
.ENDS
.SUBCKT att_4dB _net1 _net0
R2 _net1 _net0  23.7 tc1=0.0 tc2=0.0
R1 0 _net1  226 tc1=0.0 tc2=0.0
R3 0 _net0  226 tc1=0.0 tc2=0.0
.ENDS
.SUBCKT att_8dB _net1 _net0
R2 _net1 _net0  53.6 tc1=0.0 tc2=0.0
R1 0 _net1  115 tc1=0.0 tc2=0.0
R3 0 _net0  115 tc1=0.0 tc2=0.0
.ENDS
.PARAM y=1
XSUB2 _net0 _net1 att_2dB
XSUB1 _net2 _net0 att_1dB
XSUB3 _net1 _net3 att_4dB
XSUB4 _net3 _net4 att_8dB
VP1 _net2 0 dc 0 ac 0.632456 SIN(0 0.632456 1MEG) portnum 1 z0 50
VP2 _net4 0 dc 0 ac 0.632456 SIN(0 0.632456 1MEG) portnum 2 z0 50

.control

let y=1
SP DEC 100 1MEG 1G
let y = db(S[2,1])
write spice4qucs.sp1.plot S_1_1 Y_1_1 Z_1_1 S_1_2 Y_1_2 Z_1_2 S_2_1 Y_2_1 Z_2_1 S_2_2 Y_2_2 Z_2_2 y
destroy all
reset

exit
.endc
.END
